# Ansys Electronics Desktop project, version 2026.1
materials:
  vacuum: permittivity=1
  pec: conductivity=1e+30
  porcelain: permittivity=5.7
  teflon_based: permittivity=2.08 dielectric_loss_tangent=0.001
  PMLGroup1_Z_1: permittivity{anisotropic component1=1.1 component2=1.1 component3=0.45454545} permeability{anisotropic component1=1.1 component2=1.1 component3=0.45454545} dielectric_loss_tangent{anisotropic component1=1 component2=1 component3=-1} magnetic_loss_tangent{anisotropic component1=1 component2=1 component3=-1}
  PMLGroup1_XZ_1: permittivity{anisotropic component1=1 component2=0.01 component3=1} permeability{anisotropic component1=1 component2=0.01 component3=1} dielectric_loss_tangent{anisotropic component1=0 component2=242 component3=0} magnetic_loss_tangent{anisotropic component1=0 component2=242 component3=0}
  PMLGroup1_YZ_1: permittivity{anisotropic component1=0.01 component2=1 component3=1} permeability{anisotropic component1=0.01 component2=1 component3=1} dielectric_loss_tangent{anisotropic component1=242 component2=0 component3=0} magnetic_loss_tangent{anisotropic component1=242 component2=0 component3=0}
  PMLGroup1_XYZ_1: permittivity{anisotropic component1=1.1 component2=1.1 component3=1.1} permeability{anisotropic component1=1.1 component2=1.1 component3=1.1} dielectric_loss_tangent{anisotropic component1=1 component2=1 component3=1} magnetic_loss_tangent{anisotropic component1=1 component2=1 component3=1}
  PMLGroup1_Z_2: permittivity{anisotropic component1=1.1 component2=1.1 component3=0.45454545} permeability{anisotropic component1=1.1 component2=1.1 component3=0.45454545} dielectric_loss_tangent{anisotropic component1=1 component2=1 component3=-1} magnetic_loss_tangent{anisotropic component1=1 component2=1 component3=-1}
  PMLGroup1_XZ_2: permittivity{anisotropic component1=1 component2=0.01 component3=1} permeability{anisotropic component1=1 component2=0.01 component3=1} dielectric_loss_tangent{anisotropic component1=0 component2=242 component3=0} magnetic_loss_tangent{anisotropic component1=0 component2=242 component3=0}
  PMLGroup1_YZ_2: permittivity{anisotropic component1=0.01 component2=1 component3=1} permeability{anisotropic component1=0.01 component2=1 component3=1} dielectric_loss_tangent{anisotropic component1=242 component2=0 component3=0} magnetic_loss_tangent{anisotropic component1=242 component2=0 component3=0}
  PMLGroup1_XYZ_2: permittivity{anisotropic component1=1.1 component2=1.1 component3=1.1} permeability{anisotropic component1=1.1 component2=1.1 component3=1.1} dielectric_loss_tangent{anisotropic component1=1 component2=1 component3=1} magnetic_loss_tangent{anisotropic component1=1 component2=1 component3=1}
  PMLGroup2_Z_1: permittivity{anisotropic component1=1.5111191 component2=1.5111191 component3=0.3308806} permeability{anisotropic component1=1.5111191 component2=1.5111191 component3=0.3308806} dielectric_loss_tangent{anisotropic component1=1 component2=1 component3=-1} magnetic_loss_tangent{anisotropic component1=1 component2=1 component3=-1}
  PMLGroup2_XZ_1: permittivity{anisotropic component1=1 component2=0.01 component3=1} permeability{anisotropic component1=1 component2=0.01 component3=1} dielectric_loss_tangent{anisotropic component1=0 component2=456.69619 component3=0} magnetic_loss_tangent{anisotropic component1=0 component2=456.69619 component3=0}
  PMLGroup2_YZ_1: permittivity{anisotropic component1=0.01 component2=1 component3=1} permeability{anisotropic component1=0.01 component2=1 component3=1} dielectric_loss_tangent{anisotropic component1=456.69619 component2=0 component3=0} magnetic_loss_tangent{anisotropic component1=456.69619 component2=0 component3=0}
  PMLGroup2_XYZ_1: permittivity{anisotropic component1=1.5111191 component2=1.5111191 component3=1.5111191} permeability{anisotropic component1=1.5111191 component2=1.5111191 component3=1.5111191} dielectric_loss_tangent{anisotropic component1=1 component2=1 component3=1} magnetic_loss_tangent{anisotropic component1=1 component2=1 component3=1}
  PMLGroup3_Z_1: permittivity{anisotropic component1=1.5111191 component2=1.5111191 component3=0.3308806} permeability{anisotropic component1=1.5111191 component2=1.5111191 component3=0.3308806} dielectric_loss_tangent{anisotropic component1=1 component2=1 component3=-1} magnetic_loss_tangent{anisotropic component1=1 component2=1 component3=-1}
  PMLGroup3_XZ_1: permittivity{anisotropic component1=1 component2=0.01 component3=1} permeability{anisotropic component1=1 component2=0.01 component3=1} dielectric_loss_tangent{anisotropic component1=0 component2=456.69619 component3=0} magnetic_loss_tangent{anisotropic component1=0 component2=456.69619 component3=0}
  PMLGroup3_YZ_1: permittivity{anisotropic component1=0.01 component2=1 component3=1} permeability{anisotropic component1=0.01 component2=1 component3=1} dielectric_loss_tangent{anisotropic component1=456.69619 component2=0 component3=0} magnetic_loss_tangent{anisotropic component1=456.69619 component2=0 component3=0}
  PMLGroup3_XYZ_1: permittivity{anisotropic component1=1.5111191 component2=1.5111191 component3=1.5111191} permeability{anisotropic component1=1.5111191 component2=1.5111191 component3=1.5111191} dielectric_loss_tangent{anisotropic component1=1 component2=1 component3=1} magnetic_loss_tangent{anisotropic component1=1 component2=1 component3=1}
  PMLGroup4_Z_1: permittivity{anisotropic component1=1.5111191 component2=1.5111191 component3=0.3308806} permeability{anisotropic component1=1.5111191 component2=1.5111191 component3=0.3308806} dielectric_loss_tangent{anisotropic component1=1 component2=1 component3=-1} magnetic_loss_tangent{anisotropic component1=1 component2=1 component3=-1}
  PMLGroup4_XZ_1: permittivity{anisotropic component1=1 component2=0.01 component3=1} permeability{anisotropic component1=1 component2=0.01 component3=1} dielectric_loss_tangent{anisotropic component1=0 component2=456.69619 component3=0} magnetic_loss_tangent{anisotropic component1=0 component2=456.69619 component3=0}
  PMLGroup4_YZ_1: permittivity{anisotropic component1=0.01 component2=1 component3=1} permeability{anisotropic component1=0.01 component2=1 component3=1} dielectric_loss_tangent{anisotropic component1=456.69619 component2=0 component3=0} magnetic_loss_tangent{anisotropic component1=456.69619 component2=0 component3=0}
  PMLGroup4_XYZ_1: permittivity{anisotropic component1=1.5111191 component2=1.5111191 component3=1.5111191} permeability{anisotropic component1=1.5111191 component2=1.5111191 component3=1.5111191} dielectric_loss_tangent{anisotropic component1=1 component2=1 component3=1} magnetic_loss_tangent{anisotropic component1=1 component2=1 component3=1}
  PMLGroup5_Z_1: permittivity{anisotropic component1=1.7517326 component2=1.7517326 component3=0.28543169} permeability{anisotropic component1=1.7517326 component2=1.7517326 component3=0.28543169} dielectric_loss_tangent{anisotropic component1=1 component2=1 component3=-1} magnetic_loss_tangent{anisotropic component1=1 component2=1 component3=-1}
  PMLGroup5_XZ_1: permittivity{anisotropic component1=1 component2=0.01 component3=1} permeability{anisotropic component1=1 component2=0.01 component3=1} dielectric_loss_tangent{anisotropic component1=0 component2=613.71342 component3=0} magnetic_loss_tangent{anisotropic component1=0 component2=613.71342 component3=0}
  PMLGroup5_YZ_1: permittivity{anisotropic component1=0.01 component2=1 component3=1} permeability{anisotropic component1=0.01 component2=1 component3=1} dielectric_loss_tangent{anisotropic component1=613.71342 component2=0 component3=0} magnetic_loss_tangent{anisotropic component1=613.71342 component2=0 component3=0}
  PMLGroup5_XYZ_1: permittivity{anisotropic component1=1.7517326 component2=1.7517326 component3=1.7517326} permeability{anisotropic component1=1.7517326 component2=1.7517326 component3=1.7517326} dielectric_loss_tangent{anisotropic component1=1 component2=1 component3=1} magnetic_loss_tangent{anisotropic component1=1 component2=1 component3=1}
  PMLGroup1_Z_3: permittivity{anisotropic component1=1.1 component2=1.1 component3=0.45454545} permeability{anisotropic component1=1.1 component2=1.1 component3=0.45454545} dielectric_loss_tangent{anisotropic component1=1 component2=1 component3=-1} magnetic_loss_tangent{anisotropic component1=1 component2=1 component3=-1}
  PMLGroup1_XZ_3: permittivity{anisotropic component1=1 component2=0.01 component3=1} permeability{anisotropic component1=1 component2=0.01 component3=1} dielectric_loss_tangent{anisotropic component1=0 component2=242 component3=0} magnetic_loss_tangent{anisotropic component1=0 component2=242 component3=0}
  PMLGroup1_YZ_3: permittivity{anisotropic component1=0.01 component2=1 component3=1} permeability{anisotropic component1=0.01 component2=1 component3=1} dielectric_loss_tangent{anisotropic component1=242 component2=0 component3=0} magnetic_loss_tangent{anisotropic component1=242 component2=0 component3=0}
  PMLGroup1_XYZ_3: permittivity{anisotropic component1=1.1 component2=1.1 component3=1.1} permeability{anisotropic component1=1.1 component2=1.1 component3=1.1} dielectric_loss_tangent{anisotropic component1=1 component2=1 component3=1} magnetic_loss_tangent{anisotropic component1=1 component2=1 component3=1}
  PMLGroup2_Z_2: permittivity{anisotropic component1=1.5667 component2=1.5667 component3=0.31914214} permeability{anisotropic component1=1.5667 component2=1.5667 component3=0.31914214} dielectric_loss_tangent{anisotropic component1=1 component2=1 component3=-1} magnetic_loss_tangent{anisotropic component1=1 component2=1 component3=-1}
  PMLGroup2_XZ_2: permittivity{anisotropic component1=1 component2=0.01 component3=1} permeability{anisotropic component1=1 component2=0.01 component3=1} dielectric_loss_tangent{anisotropic component1=0 component2=490.90979 component3=0} magnetic_loss_tangent{anisotropic component1=0 component2=490.90979 component3=0}
  PMLGroup2_YZ_2: permittivity{anisotropic component1=0.01 component2=1 component3=1} permeability{anisotropic component1=0.01 component2=1 component3=1} dielectric_loss_tangent{anisotropic component1=490.90979 component2=0 component3=0} magnetic_loss_tangent{anisotropic component1=490.90979 component2=0 component3=0}
  PMLGroup2_XYZ_2: permittivity{anisotropic component1=1.5667 component2=1.5667 component3=1.5667} permeability{anisotropic component1=1.5667 component2=1.5667 component3=1.5667} dielectric_loss_tangent{anisotropic component1=1 component2=1 component3=1} magnetic_loss_tangent{anisotropic component1=1 component2=1 component3=1}
  PMLGroup3_Z_2: permittivity{anisotropic component1=1.5667 component2=1.5667 component3=0.31914214} permeability{anisotropic component1=1.5667 component2=1.5667 component3=0.31914214} dielectric_loss_tangent{anisotropic component1=1 component2=1 component3=-1} magnetic_loss_tangent{anisotropic component1=1 component2=1 component3=-1}
  PMLGroup3_XZ_2: permittivity{anisotropic component1=1 component2=0.01 component3=1} permeability{anisotropic component1=1 component2=0.01 component3=1} dielectric_loss_tangent{anisotropic component1=0 component2=490.90979 component3=0} magnetic_loss_tangent{anisotropic component1=0 component2=490.90979 component3=0}
  PMLGroup3_YZ_2: permittivity{anisotropic component1=0.01 component2=1 component3=1} permeability{anisotropic component1=0.01 component2=1 component3=1} dielectric_loss_tangent{anisotropic component1=490.90979 component2=0 component3=0} magnetic_loss_tangent{anisotropic component1=490.90979 component2=0 component3=0}
  PMLGroup3_XYZ_2: permittivity{anisotropic component1=1.5667 component2=1.5667 component3=1.5667} permeability{anisotropic component1=1.5667 component2=1.5667 component3=1.5667} dielectric_loss_tangent{anisotropic component1=1 component2=1 component3=1} magnetic_loss_tangent{anisotropic component1=1 component2=1 component3=1}

design Finite GND (HFSS, HFSS Terminal Network, model units mm)
variables:
  f0 = 2GHz
  lambda = c0/f0
  h_ant = 35mm
  r_ant = 0.65mm
  r_GND = 0.05meter
  r_coax = 2.2mm
  h_coax = h_GND
  r_calcul = 3*lambda
  h_GND = 0.5mm
geometry:
  Monopole [pec] = cylinder(axis=Z, base_centre=(0mm, 0mm, -h_coax), radius=r_ant, height=h_ant+h_coax)
  GND [pec] = cylinder(axis=Z, base_centre=(0mm, 0mm, 0mm), radius=r_GND, height=-h_GND)
  Cylinder1 [teflon_based] = cylinder(axis=Z, base_centre=(0mm, 0mm, 0mm), radius=r_coax, height=-h_coax)
  Cylinder1_1 = Cylinder1.copy()
  GND.subtract(Cylinder1_1)
  Monopole_1 = Monopole.copy()
  Cylinder1.subtract(Monopole_1)
  RadiatingSurface [vacuum] = region(absolute_offset=37.5mm on all sides)
  coordinate_system FaceCS1 = face of RadiatingSurface: Origin=(87.5, -87.5, 72.5) FaceID=RadiatingSurface.face(+z) AxisPosn=(87.5, 87.5, 72.5) WhichAxis=X ZRotationAngle=0deg XOffset=0mm YOffset=0mm FaceNormal(0, 0, 1)
  PML_RadiatingSurface_1 [PMLGroup1_Z_1, oriented by FaceCS1] = sweep_along_normal(RadiatingSurface.face(+z), length=145.58101mm)
  coordinate_system FaceCS2 = face of RadiatingSurface: Origin=(87.5, -87.5, -38) FaceID=RadiatingSurface.face(-z) AxisPosn=(-87.5, -87.5, -38) WhichAxis=X ZRotationAngle=0deg XOffset=0mm YOffset=0mm FaceNormal(0, 0, -1)
  PML_RadiatingSurface_2 [PMLGroup1_Z_1, oriented by FaceCS2] = sweep_along_normal(RadiatingSurface.face(-z), length=145.58101mm)
  coordinate_system FaceCS3 = face of RadiatingSurface: Origin=(87.5, -87.5, 72.5) FaceID=RadiatingSurface.face(-y) AxisPosn=(-87.5, -87.5, 72.5) WhichAxis=X ZRotationAngle=0deg XOffset=0mm YOffset=0mm FaceNormal(0, -1, 0)
  PML_RadiatingSurface_3 [PMLGroup1_Z_1, oriented by FaceCS3] = sweep_along_normal(RadiatingSurface.face(-y), length=145.58101mm)
  coordinate_system FaceCS4 = face of RadiatingSurface: Origin=(-87.5, -87.5, 72.5) FaceID=RadiatingSurface.face(-x) AxisPosn=(-87.5, 87.5, 72.5) WhichAxis=X ZRotationAngle=0deg XOffset=0mm YOffset=0mm FaceNormal(-1, 0, 0)
  PML_RadiatingSurface_4 [PMLGroup1_Z_1, oriented by FaceCS4] = sweep_along_normal(RadiatingSurface.face(-x), length=145.58101mm)
  coordinate_system FaceCS5 = face of RadiatingSurface: Origin=(-87.5, 87.5, 72.5) FaceID=RadiatingSurface.face(+y) AxisPosn=(87.5, 87.5, 72.5) WhichAxis=X ZRotationAngle=0deg XOffset=0mm YOffset=0mm FaceNormal(0, 1, 0)
  PML_RadiatingSurface_5 [PMLGroup1_Z_1, oriented by FaceCS5] = sweep_along_normal(RadiatingSurface.face(+y), length=145.58101mm)
  coordinate_system FaceCS6 = face of RadiatingSurface: Origin=(87.5, 87.5, -38) FaceID=RadiatingSurface.face(+x) AxisPosn=(87.5, 87.5, 72.5) WhichAxis=X ZRotationAngle=0deg XOffset=0mm YOffset=0mm FaceNormal(1, 0, 0)
  PML_RadiatingSurface_6 [PMLGroup1_Z_1, oriented by FaceCS6] = sweep_along_normal(RadiatingSurface.face(+x), length=145.58101mm)
  PML_RadiatingSurface_7 [PMLGroup1_XZ_1, oriented by FaceCS1] = sweep_along_normal(PML_RadiatingSurface_1.face(at (0, -87.5, 145.291)), length=145.58101mm)
  PML_RadiatingSurface_8 [PMLGroup1_YZ_1, oriented by FaceCS4] = sweep_along_normal(PML_RadiatingSurface_1.face(at (-87.5, 0, 145.291)), length=145.58101mm)
  PML_RadiatingSurface_9 [PMLGroup1_YZ_1, oriented by FaceCS5] = sweep_along_normal(PML_RadiatingSurface_1.face(at (0, 87.5, 145.291)), length=145.58101mm)
  PML_RadiatingSurface_10 [PMLGroup1_YZ_1, oriented by FaceCS1] = sweep_along_normal(PML_RadiatingSurface_1.face(at (87.5, 0, 145.291)), length=145.58101mm)
  PML_RadiatingSurface_11 [PMLGroup1_YZ_1, oriented by FaceCS2] = sweep_along_normal(PML_RadiatingSurface_2.face(at (0, -87.5, -110.791)), length=145.58101mm)
  coordinate_system FaceCS7 = face of RadiatingSurface: Origin=(-87.5, -87.5, -38) FaceID=RadiatingSurface.face(-z) AxisPosn=(-87.5, 87.5, -38) WhichAxis=X ZRotationAngle=0deg XOffset=0mm YOffset=0mm FaceNormal(0, 0, -1)
  PML_RadiatingSurface_12 [PMLGroup1_YZ_1, oriented by FaceCS7] = sweep_along_normal(PML_RadiatingSurface_2.face(at (-87.5, 0, -110.791)), length=145.58101mm)
  coordinate_system FaceCS8 = face of RadiatingSurface: Origin=(-87.5, 87.5, -38) FaceID=RadiatingSurface.face(-z) AxisPosn=(87.5, 87.5, -38) WhichAxis=X ZRotationAngle=0deg XOffset=0mm YOffset=0mm FaceNormal(0, 0, -1)
  PML_RadiatingSurface_13 [PMLGroup1_YZ_1, oriented by FaceCS8] = sweep_along_normal(PML_RadiatingSurface_2.face(at (0, 87.5, -110.791)), length=145.58101mm)
  PML_RadiatingSurface_14 [PMLGroup1_XZ_1, oriented by FaceCS2] = sweep_along_normal(PML_RadiatingSurface_2.face(at (87.5, 0, -110.791)), length=145.58101mm)
  PML_RadiatingSurface_15 [PMLGroup1_XZ_1, oriented by FaceCS4] = sweep_along_normal(PML_RadiatingSurface_3.face(at (-87.5, -160.291, 17.25)), length=145.58101mm)
  PML_RadiatingSurface_16 [PMLGroup1_XZ_1, oriented by FaceCS3] = sweep_along_normal(PML_RadiatingSurface_3.face(at (87.5, -160.291, 17.25)), length=145.58101mm)
  PML_RadiatingSurface_17 [PMLGroup1_XZ_1, oriented by FaceCS5] = sweep_along_normal(PML_RadiatingSurface_4.face(at (-160.291, 87.5, 17.25)), length=145.58101mm)
  PML_RadiatingSurface_18 [PMLGroup1_YZ_1, oriented by FaceCS6] = sweep_along_normal(PML_RadiatingSurface_5.face(at (87.5, 160.291, 17.25)), length=145.58101mm)
  PML_RadiatingSurface_19 [PMLGroup1_XYZ_1, oriented by FaceCS4] = sweep_along_normal(PML_RadiatingSurface_7.face(at (-87.5, -160.291, 145.291)), length=145.58101mm)
  PML_RadiatingSurface_20 [PMLGroup1_XYZ_1, oriented by FaceCS1] = sweep_along_normal(PML_RadiatingSurface_7.face(at (87.5, -160.291, 145.291)), length=145.58101mm)
  PML_RadiatingSurface_21 [PMLGroup1_XYZ_1, oriented by FaceCS5] = sweep_along_normal(PML_RadiatingSurface_8.face(at (-160.291, 87.5, 145.291)), length=145.58101mm)
  coordinate_system FaceCS9 = face of RadiatingSurface: Origin=(87.5, 87.5, 72.5) FaceID=RadiatingSurface.face(+z) AxisPosn=(-87.5, 87.5, 72.5) WhichAxis=X ZRotationAngle=0deg XOffset=0mm YOffset=0mm FaceNormal(0, 0, 1)
  PML_RadiatingSurface_22 [PMLGroup1_XYZ_1, oriented by FaceCS9] = sweep_along_normal(PML_RadiatingSurface_9.face(at (87.5, 160.291, 145.291)), length=145.58101mm)
  PML_RadiatingSurface_23 [PMLGroup1_XYZ_1, oriented by FaceCS7] = sweep_along_normal(PML_RadiatingSurface_11.face(at (-87.5, -160.291, -110.791)), length=145.58101mm)
  PML_RadiatingSurface_24 [PMLGroup1_XYZ_1, oriented by FaceCS2] = sweep_along_normal(PML_RadiatingSurface_11.face(at (87.5, -160.291, -110.791)), length=145.58101mm)
  PML_RadiatingSurface_25 [PMLGroup1_XYZ_1, oriented by FaceCS8] = sweep_along_normal(PML_RadiatingSurface_12.face(at (-160.291, 87.5, -110.791)), length=145.58101mm)
  PML_RadiatingSurface_26 [PMLGroup1_XYZ_1, oriented by FaceCS6] = sweep_along_normal(PML_RadiatingSurface_13.face(at (87.5, 160.291, -110.791)), length=145.58101mm)
  group PMLGroup1 = PML_RadiatingSurface_1..PML_RadiatingSurface_26
boundaries and excitations:
  PML_radiation1: Radiation Faces=RadiatingSurface.face(+z) IsForPML
  PML_radiation2: Radiation Faces=RadiatingSurface.face(-z) IsForPML
  PML_radiation3: Radiation Faces=RadiatingSurface.face(-y) IsForPML
  PML_radiation4: Radiation Faces=RadiatingSurface.face(-x) IsForPML
  PML_radiation5: Radiation Faces=RadiatingSurface.face(+y) IsForPML
  PML_radiation6: Radiation Faces=RadiatingSurface.face(+x) IsForPML
  1: Wave Port Faces=Cylinder1.face(-z end) WavePortType=Modal NumModes=1 Modes{Mode1{CharImp=Zpi}}
setups:
  Setup1: HfssDriven Frequency=2GHz MaxDeltaS=0.01 MaximumPasses=20 MinimumPasses=1 MinimumConvergedPasses=1 PercentRefinement=30 BasisOrder=1 PortAccuracy=2 DrivenSolverType="Direct Solver"
    sweep Sweep: 1GHz to 3GHz step 0.1GHz; Type=Interpolating SaveFields SaveRadFields InterpTolerance=0.5 InterpMaxSolns=250 PassivityErrorTolerance=0.0001
source amplitudes:
  1:1: 1V 0deg
optimetrics:
  ParametricSetup1: Parametric Sim._Setups=[Setup1]
    sweep r_GND: LINC 0.01meter 0.1meter 3
    table edits: edit(0.055meter, 0.05meter)
radiation setups:
  3D: Infinite Sphere Theta=0deg..180deg step 2deg Phi=-180deg..180deg step 2deg
  Elevation: Infinite Sphere Theta=-180deg..180deg step 1deg Phi=0deg..90deg step 90deg
  Azimuth: Infinite Sphere Theta=90deg..90deg step 0deg Phi=-180deg..180deg step 1deg
reports:
  Port Zo Plot1: re(Zo(1)) vs Freq on Setup1 : Sweep
  S Parameter Chart1: S(1,1) on Setup1 : Sweep [Freq=all]
  Gain Plot1: dB(GainTotal) vs Phi, Theta on Setup1 : LastAdaptive, 3D [Freq=2GHz]
  Gain Plot2: GainTotal vs Theta on Setup1 : LastAdaptive, 3D [Phi=0deg Freq=2GHz]
  Gain Plot3: dB(GainPhi), dB(GainTheta) vs Theta on Setup1 : LastAdaptive, 3D [Phi=0deg Freq=2GHz]

design Infinite GND (HFSS, HFSS Terminal Network, model units mm)
variables:
  f0 = 2GHz
  lambda = (c0/f0) meter
  h_ant = 35mm
  r_ant = 0.65mm
  r_GND = 0.1meter
  r_coax = 2.2mm
  h_coax = 0.1m
  r_calcul = 3*lambda meter
  h_GND = 0mm
geometry:
  Monopole [pec] = cylinder(axis=Z, base_centre=(0mm, 0mm, 0), radius=r_ant, height=h_ant+h_coax)
  Cylinder1 [teflon_based] = cylinder(axis=Z, base_centre=(0mm, 0mm, 0mm), radius=r_coax, height=h_coax)
  Monopole_1 = Monopole.copy()
  Cylinder1.subtract(Monopole_1)
  RadiatingSurface [vacuum] = region(absolute_offset: +X=37.5mm, -X=37.5mm, +Y=37.5mm, -Y=37.5mm, +Z=37.5mm, -Z=0)
  coordinate_system FaceCS1 = face of RadiatingSurface: Origin=(39.7, -39.7, 72.6) FaceID=RadiatingSurface.face(+z) AxisPosn=(39.7, 39.7, 72.6) WhichAxis=X ZRotationAngle=0deg XOffset=0mm YOffset=0mm FaceNormal(0, 0, 1)
  PML_RadiatingSurface_1 [PMLGroup3_Z_2, oriented by FaceCS1] = sweep_along_normal(RadiatingSurface.face(+z), length=42.810659mm)
  coordinate_system FaceCS2 = face of RadiatingSurface: Origin=(39.7, -39.7, 72.6) FaceID=RadiatingSurface.face(-y) AxisPosn=(-39.7, -39.7, 72.6) WhichAxis=X ZRotationAngle=0deg XOffset=0mm YOffset=0mm FaceNormal(0, -1, 0)
  PML_RadiatingSurface_2 [PMLGroup3_Z_2, oriented by FaceCS2] = sweep_along_normal(RadiatingSurface.face(-y), length=42.810659mm)
  coordinate_system FaceCS3 = face of RadiatingSurface: Origin=(-39.7, -39.7, 72.6) FaceID=RadiatingSurface.face(-x) AxisPosn=(-39.7, 39.7, 72.6) WhichAxis=X ZRotationAngle=0deg XOffset=0mm YOffset=0mm FaceNormal(-1, 0, 0)
  PML_RadiatingSurface_3 [PMLGroup3_Z_2, oriented by FaceCS3] = sweep_along_normal(RadiatingSurface.face(-x), length=42.810659mm)
  coordinate_system FaceCS4 = face of RadiatingSurface: Origin=(-39.7, 39.7, 72.6) FaceID=RadiatingSurface.face(+y) AxisPosn=(39.7, 39.7, 72.6) WhichAxis=X ZRotationAngle=0deg XOffset=0mm YOffset=0mm FaceNormal(0, 1, 0)
  PML_RadiatingSurface_4 [PMLGroup3_Z_2, oriented by FaceCS4] = sweep_along_normal(RadiatingSurface.face(+y), length=42.810659mm)
  coordinate_system FaceCS5 = face of RadiatingSurface: Origin=(39.7, 39.7, 0) FaceID=RadiatingSurface.face(+x) AxisPosn=(39.7, 39.7, 72.6) WhichAxis=X ZRotationAngle=0deg XOffset=0mm YOffset=0mm FaceNormal(1, 0, 0)
  PML_RadiatingSurface_5 [PMLGroup3_Z_2, oriented by FaceCS5] = sweep_along_normal(RadiatingSurface.face(+x), length=42.810659mm)
  PML_RadiatingSurface_6 [PMLGroup3_XZ_2, oriented by FaceCS1] = sweep_along_normal(PML_RadiatingSurface_1.face(at (0, -39.7, 94.0053)), length=42.810659mm)
  PML_RadiatingSurface_7 [PMLGroup3_YZ_2, oriented by FaceCS3] = sweep_along_normal(PML_RadiatingSurface_1.face(at (-39.7, 0, 94.0053)), length=42.810659mm)
  PML_RadiatingSurface_8 [PMLGroup3_YZ_2, oriented by FaceCS4] = sweep_along_normal(PML_RadiatingSurface_1.face(at (0, 39.7, 94.0053)), length=42.810659mm)
  PML_RadiatingSurface_9 [PMLGroup3_YZ_2, oriented by FaceCS1] = sweep_along_normal(PML_RadiatingSurface_1.face(at (39.7, 0, 94.0053)), length=42.810659mm)
  PML_RadiatingSurface_10 [PMLGroup3_XZ_2, oriented by FaceCS3] = sweep_along_normal(PML_RadiatingSurface_2.face(at (-39.7, -61.1053, 36.3)), length=42.810659mm)
  PML_RadiatingSurface_11 [PMLGroup3_XZ_2, oriented by FaceCS2] = sweep_along_normal(PML_RadiatingSurface_2.face(at (39.7, -61.1053, 36.3)), length=42.810659mm)
  PML_RadiatingSurface_12 [PMLGroup3_XZ_2, oriented by FaceCS4] = sweep_along_normal(PML_RadiatingSurface_3.face(at (-61.1053, 39.7, 36.3)), length=42.810659mm)
  PML_RadiatingSurface_13 [PMLGroup3_YZ_2, oriented by FaceCS5] = sweep_along_normal(PML_RadiatingSurface_4.face(at (39.7, 61.1053, 36.3)), length=42.810659mm)
  PML_RadiatingSurface_14 [PMLGroup3_XYZ_2, oriented by FaceCS3] = sweep_along_normal(PML_RadiatingSurface_6.face(at (-39.7, -61.1053, 94.0053)), length=42.810659mm)
  PML_RadiatingSurface_15 [PMLGroup3_XYZ_2, oriented by FaceCS1] = sweep_along_normal(PML_RadiatingSurface_6.face(at (39.7, -61.1053, 94.0053)), length=42.810659mm)
  PML_RadiatingSurface_16 [PMLGroup3_XYZ_2, oriented by FaceCS4] = sweep_along_normal(PML_RadiatingSurface_7.face(at (-61.1053, 39.7, 94.0053)), length=42.810659mm)
  coordinate_system FaceCS6 = face of RadiatingSurface: Origin=(39.7, 39.7, 72.6) FaceID=RadiatingSurface.face(+z) AxisPosn=(-39.7, 39.7, 72.6) WhichAxis=X ZRotationAngle=0deg XOffset=0mm YOffset=0mm FaceNormal(0, 0, 1)
  PML_RadiatingSurface_17 [PMLGroup3_XYZ_2, oriented by FaceCS6] = sweep_along_normal(PML_RadiatingSurface_8.face(at (39.7, 61.1053, 94.0053)), length=42.810659mm)
  group PMLGroup3 = PML_RadiatingSurface_1..PML_RadiatingSurface_17
boundaries and excitations:
  PML_radiation1: Radiation Faces=RadiatingSurface.face(+z) IsForPML
  PML_radiation2: Radiation Faces=RadiatingSurface.face(-y) IsForPML
  PML_radiation3: Radiation Faces=RadiatingSurface.face(-x) IsForPML
  PML_radiation4: Radiation Faces=RadiatingSurface.face(+y) IsForPML
  PML_radiation5: Radiation Faces=RadiatingSurface.face(+x) IsForPML
  Open_InfiniteGnd1: Perfect E Faces=RadiatingSurface.face(-z) InfGroundPlane
  1: Wave Port Faces=Cylinder1.face(-z end) WavePortType=Modal NumModes=1 Modes{Mode1{CharImp=Zpi}}
setups:
  Setup1: HfssDriven Frequency=2GHz MaxDeltaS=0.01 MaximumPasses=20 MinimumPasses=1 MinimumConvergedPasses=1 PercentRefinement=30 BasisOrder=1 PortAccuracy=2 DrivenSolverType="Direct Solver"
    sweep Sweep: 1GHz to 3GHz step 0.1GHz; Type=Interpolating SaveFields SaveRadFields InterpTolerance=0.5 InterpMaxSolns=250 PassivityErrorTolerance=0.0001
source amplitudes:
  1:1: 1V 0deg
radiation setups:
  3D: Infinite Sphere Theta=0deg..180deg step 2deg Phi=-180deg..180deg step 2deg
  Elevation: Infinite Sphere Theta=-180deg..180deg step 1deg Phi=0deg..90deg step 90deg
  Azimuth: Infinite Sphere Theta=90deg..90deg step 0deg Phi=-180deg..180deg step 1deg
reports:
  Port Zo Plot1: re(Zo(1)) vs Freq on Setup1 : Sweep
  S Parameter Chart1: S(1,1) on Setup1 : Sweep [Freq=all]; markers m1 at 2GHz
  Gain Plot1: dB(GainTotal) vs Phi, Theta on Setup1 : LastAdaptive, 3D [Freq=2GHz]
  Gain Plot2: dB(GainTotal) vs Theta on Setup1 : LastAdaptive, 3D [Phi=0deg Freq=2GHz]; markers m1 at 90deg
